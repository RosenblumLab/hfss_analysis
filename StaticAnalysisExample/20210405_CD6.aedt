# Ansys Electronics Desktop project, version 2020.2
project variables:
  $chip_thickness = 0.28mm
  $jj_w = 4um
  $antenna_L = 1.4mm
  $pad_L = 400um
  $lead_L = 70um
  $antenna_depth = 675um
  $jj_L = 10um
  $chip_w = 2mm
  $coax_L = 2.4cm
  $chip_penetration = 2.75mm
  $pad_w = 1000um
  $ro_w = 0.15mm
  $ro_gap = 0.85mm
  $ro_L = 14mm
  $antenna_R = 0.25mm
  $antenna_w = 0.1mm
  $lead_w = 20um
  $chip_surrounder_radius = 7.9mm
  $PinHoleRadius = 0.7mm
  $PinRadius = 0.3mm
  $chip_surrounder_radius_small = 2mm
  $CavityEnd = -40m
  $SapphireHouseStart = -46mm
  $feedthrough_plate_z = 12.105mm
  $feedthrough_coax_outer_radius = 3.861mm
  $feedthrough_pin_radius = 0.508mm
  $CavityStart = 9mm
  $feedthrough_pin_length = 3.5mm
  $SapphireHouseEnd = -62.75mm
  $loss_tan = 0.001
  $chip_L = 25.5mm
materials:
  vacuum: permittivity=1
  perfect conductor: conductivity=1e+30
  sapphire: permittivity=10
  LossySapphire: permittivity=10 dielectric_loss_tangent=$loss_tan
  copper: permeability=0.999991 conductivity=58000000
  plexiglass: permittivity=3.4 dielectric_loss_tangent=0.001
  silicon: permittivity=11.9
  magnesium: conductivity=22500000
  silicon_lossy: permittivity=11.9 dielectric_loss_tangent=$loss_tan
  silicon_nitrate: permittivity=7

design Chip (HFSS, Eigenmode, model units mm)
variables:
  chip_pos = 0.8mm
geometry:
  rect_jj1 = rectangle(corner=(-$chip_thickness/2, -$jj_w/2, $CavityEnd+$chip_penetration-$antenna_depth-$antenna_L-$lead_L-$pad_L), y_size=$jj_w, z_size=-$jj_L)
  line_jj1 = polyline((-$chip_thickness/2, 0mm, $CavityEnd+$chip_penetration-$antenna_depth-$antenna_L-$lead_L-$pad_L) (-$chip_thickness/2, 0mm, $CavityEnd+$chip_penetration-$antenna_depth-$antenna_L-$lead_L-$pad_L-$jj_L))
  chip_holder1 [silicon] = box(corner=(-$chip_thickness/2, -$chip_w/2, $CavityEnd+$chip_penetration), size=($chip_thickness, $chip_w, -$chip_L))
  Transmon1 = rectangle(corner=(-$chip_thickness/2, -$pad_w/2, $CavityEnd+$chip_penetration-$antenna_depth-$antenna_L), y_size=$pad_w, z_size=-$pad_L)
  Rectangle15 = rectangle(corner=(-$chip_thickness/2, -$antenna_w/2, $CavityEnd+$chip_penetration-$antenna_depth), y_size=$antenna_w, z_size=-$antenna_L)
  Circle2 = circle(normal=X, centre=(-$chip_thickness/2, 0mm, $CavityEnd+$chip_penetration-$antenna_depth), radius=$antenna_R)
  Rectangle16 = rectangle(corner=(-$chip_thickness/2, -$lead_w/2, $CavityEnd+$chip_penetration-$antenna_depth-$antenna_L-$pad_L), y_size=$lead_w, z_size=-$lead_L)
  Transmon1.unite(Rectangle15, Circle2, Rectangle16)
  Transmon2 = rectangle(corner=(-$chip_thickness/2, -$pad_w/2, $CavityEnd+$chip_penetration-$antenna_depth-$antenna_L-$lead_L-$pad_L-$jj_L-$lead_L), y_size=$pad_w, z_size=-$pad_L)
  Rectangle17 = rectangle(corner=(-$chip_thickness/2, -$lead_w/2, $CavityEnd+$chip_penetration-$antenna_depth-$antenna_L-$lead_L-$pad_L-$jj_L), y_size=$lead_w, z_size=-$lead_L)
  Transmon2.unite(Rectangle17)
  ROresonator = rectangle(corner=(-$chip_thickness/2, -$ro_w/2, $CavityEnd+$chip_penetration-$antenna_depth-$antenna_L-$lead_L-$pad_L-$jj_L-$lead_L-$pad_L-$ro_gap), y_size=$ro_w, z_size=-$ro_L)
  group TransmonChip = rect_jj1, line_jj1, chip_holder1, Transmon1, Transmon2, ROresonator

design Cavity (HFSS, Eigenmode, model units mm)
variables:
  PinHolePos = 13mm  # optimise -88.5mm..-29.5mm
  PinHeight = 1.4mm
  chip_pos = 0.8mm
  PinHolePos2 = 8.9mm
  PinHeight2 = 2.4mm
  Lj = 5.35nH
  ReadoutPinLength = 6.3mm
  ReadoutPinHeight = 1.46mm
  DrivePinLength = 5.35mm
  DrivePinHeight = 2.69mm
geometry:
  SapphireHouse [perfect conductor] = cylinder(axis=Z, base_centre=(0mm, 0mm, $SapphireHouseStart), radius=$chip_surrounder_radius, height=$SapphireHouseEnd - ($SapphireHouseStart))
  ReadoutPin [perfect conductor] = cylinder(axis=X, base_centre=((-$chip_thickness/2) - ReadoutPinHeight, 0mm, $CavityEnd - PinHolePos), radius=$PinRadius, height=-ReadoutPinLength)
  Vacuum [vacuum] = cylinder(axis=Z, base_centre=(0mm, 0mm, $feedthrough_plate_z), radius=$chip_surrounder_radius_small, height=$SapphireHouseEnd - $feedthrough_plate_z)
  Cylinder2 = cylinder(axis=Z, base_centre=(0mm, 0mm, -16.5mm), radius=31m, height=$CavityEnd + 16.5 mm)
  PinHole2 = cylinder(axis=X, base_centre=(0, 0mm, $CavityEnd - PinHolePos), radius=$PinHoleRadius, height=-$chip_surrounder_radius)
  Cylinder3 = cylinder(axis=Z, base_centre=(0mm, 0mm, $CavityStart), radius=8mm, height=-27mm)
  Vacuum.unite(Cylinder2, Cylinder3, PinHole2)
  PinHole3 = cylinder(axis=X, base_centre=(0, 0mm, $CavityEnd - PinHolePos2), radius=$PinHoleRadius, height=$chip_surrounder_radius)
  Vacuum.unite(PinHole3)
  DrivePin [perfect conductor] = cylinder(axis=X, base_centre=((-$chip_thickness/2) + DrivePinHeight, 0mm, $CavityEnd - PinHolePos2), radius=$PinRadius, height=DrivePinLength)
  chip_holder1 = box(corner=(-$chip_thickness/2, -$chip_w/2, $coax_L), size=($chip_thickness, $chip_w, -$coax_L-$chip_penetration))
  chip_holder1.rotate(axis=Y, angle=180deg)
  chip_holder1.rotate(axis=Z, angle=180deg)
  chip_holder1.move(0mm, 0mm, $CavityEnd + chip_pos)
  feedthrough_outer_coax = cylinder(axis=Z, base_centre=(0mm, 0mm, $feedthrough_plate_z), radius=$feedthrough_coax_outer_radius, height=-$feedthrough_plate_z)
  feedthrough_pin [perfect conductor] = cylinder(axis=Z, base_centre=(0mm, 0mm, ($feedthrough_plate_z)), radius=$feedthrough_pin_radius, height=-$feedthrough_pin_length)
  Chamber7CavityB_2 [perfect conductor] = imported_body(C:\Users\barkayg\Dropbox (Weizmann Institute)\Quantum Circuits Lab\Barkay\SRF Cavity\Simulations\CavityQubit4Simulation.stp)
  SeamLine [non-model] = polyline((0, 2mm, $CavityEnd-6 mm) (-1.7453293e-06mm, -2mm, -46mm) (3.4906585e-06mm, 2mm, -46mm), AngularArc from point 0 over 3 centre=(0mm, 0mm, $CavityEnd-6 mm) angle=359.9999deg plane=XY)
  Chamber7Saphirdia4 [perfect conductor] = imported_body(C:\Users\barkayg\Dropbox (Weizmann Institute)\Quantum Circuits Lab\Barkay\SRF Cavity\Design\2020_12_15\Chamber 7 dia4.stp)
  Chamber7CavityB_2_1 = Chamber7CavityB_2.copy()
  Chamber7Saphirdia4_2 = Chamber7Saphirdia4.copy()
  Vacuum.subtract(Chamber7CavityB_2_1, Chamber7Saphirdia4_2)
  Vacuum.unite(feedthrough_outer_coax)
  feedthrough_pin1 = cylinder(axis=Z, base_centre=(0mm, 0mm, ($feedthrough_plate_z)), radius=2.184mm, height=-0.01mm)
  feedthrough_pin.unite(feedthrough_pin1)
  Chamber7Saphirdia4_3 = Chamber7Saphirdia4.copy()
  chip_holder1_1 = chip_holder1.copy()
  DrivePin_1 = DrivePin.copy()
  ReadoutPin_1 = ReadoutPin.copy()
  Vacuum_1 = Vacuum.copy()
  SapphireHouse.subtract(Chamber7Saphirdia4_3, chip_holder1_1, DrivePin_1, ReadoutPin_1, Vacuum_1)
  chip_holder1.delete()
  rect_jj1 = rectangle(corner=(-$chip_thickness/2, -$jj_w/2, $CavityEnd+$chip_penetration-$antenna_depth-$antenna_L-$lead_L-$pad_L), y_size=$jj_w, z_size=-$jj_L)
  line_jj1 = polyline((-$chip_thickness/2, 0mm, $CavityEnd+$chip_penetration-$antenna_depth-$antenna_L-$lead_L-$pad_L) (-$chip_thickness/2, 0mm, $CavityEnd+$chip_penetration-$antenna_depth-$antenna_L-$lead_L-$pad_L-$jj_L))
  chip_holder2 [silicon_lossy] = box(corner=(-$chip_thickness/2, -$chip_w/2, $CavityEnd+$chip_penetration), size=($chip_thickness, $chip_w, -$chip_L))
  Transmon1 = rectangle(corner=(-$chip_thickness/2, -$pad_w/2, $CavityEnd+$chip_penetration-$antenna_depth-$antenna_L), y_size=$pad_w, z_size=-$pad_L)
  Rectangle15 = rectangle(corner=(-$chip_thickness/2, -$antenna_w/2, $CavityEnd+$chip_penetration-$antenna_depth), y_size=$antenna_w, z_size=-$antenna_L)
  Circle2 = circle(normal=X, centre=(-$chip_thickness/2, 0mm, $CavityEnd+$chip_penetration-$antenna_depth), radius=$antenna_R)
  Rectangle16 = rectangle(corner=(-$chip_thickness/2, -$lead_w/2, $CavityEnd+$chip_penetration-$antenna_depth-$antenna_L-$pad_L), y_size=$lead_w, z_size=-$lead_L)
  Transmon1.unite(Rectangle15, Circle2, Rectangle16)
  Transmon2 = rectangle(corner=(-$chip_thickness/2, -$pad_w/2, $CavityEnd+$chip_penetration-$antenna_depth-$antenna_L-$lead_L-$pad_L-$jj_L-$lead_L), y_size=$pad_w, z_size=-$pad_L)
  Rectangle17 = rectangle(corner=(-$chip_thickness/2, -$lead_w/2, $CavityEnd+$chip_penetration-$antenna_depth-$antenna_L-$lead_L-$pad_L-$jj_L), y_size=$lead_w, z_size=-$lead_L)
  Transmon2.unite(Rectangle17)
  ROresonator = rectangle(corner=(-$chip_thickness/2, -$ro_w/2, $CavityEnd+$chip_penetration-$antenna_depth-$antenna_L-$lead_L-$pad_L-$jj_L-$lead_L-$pad_L-$ro_gap), y_size=$ro_w, z_size=-$ro_L)
  group feedthrough_Group = feedthrough_pin
  group CavityQubit4Simulation = Chamber7CavityB_2, Chamber7Saphirdia4
  group TransmonChip = rect_jj1, line_jj1, chip_holder2, Transmon1, Transmon2, ROresonator
boundaries and excitations:
  ReadoutPinImpedance: Lumped RLC Faces=Vacuum.face(2 of 3) CurrentLine{ReadoutPin.edge(1 of 2) at -0.25 along -> Vacuum.edge(1 of 2) at -0.25 along} RLC_Type=Parallel Resistance=50ohm
  DrivePinImpedance: Lumped RLC Faces=Vacuum.face(3 of 3) CurrentLine{DrivePin.edge(2 of 2) at 0.25 along -> Vacuum.edge(2 of 2) at 0.25 along} RLC_Type=Parallel Resistance=50ohm
  CavityPinImpedance: Lumped RLC Faces=Vacuum.face(3 of 3) CurrentLine{feedthrough_pin.vertex(2 of 2) -> Vacuum.vertex(2 of 2)} RLC_Type=Parallel Resistance=50ohm
  SCelements: Perfect E Objects=[ROresonator, Transmon1, Transmon2]
  Lj: Lumped RLC Objects=rect_jj1 CurrentLine{middle of rect_jj1.edge(z opposite corner) -> middle of rect_jj1.edge(z at corner)} RLC_Type=Parallel Inductance=Lj
mesh:
  ChipSCs: LengthBased Objects=[Transmon2, ROresonator, Transmon1] MaxLength=0.1mm
  jj: LengthBased Objects=rect_jj1 MaxLength=4um
setups:
  Setup1: HfssEigen MinimumFrequency=3GHz NumModes=5 MaxDeltaFreq=0.4 ConvergeOnRealFreq=true MaximumPasses=16 MinimumPasses=3 MinimumConvergedPasses=2 PercentRefinement=30 BasisOrder=-1
source amplitudes:
  #-10:1, #-10:2, #-10:4, #-10:5: 0 0
  #-10:3: 1 0
field calculator expressions:
  Surface_Current_Seam = Fundamental_Quantity(1) | ScalarZ | Fundamental_Quantity(1) | ScalarZ | Conj | * | Real | EnterLine(SeamLine) | LineValue | Integrate | <Hx,Hy,Hz> | <Hx,Hy,Hz> | Conj | Dot | Real | EnterVolume(Vacuum) | VolumeValue | Integrate | /
field plots:
  Mag_E1, Vector_E1: E Field in Vacuum on Setup1 : LastAdaptive at Phase=0deg
  Vector_E2: E Field on Setup1 : LastAdaptive at Phase=0deg
  Mesh1, Mesh2: MeshPlots in chip_holder2 on Setup1 : LastAdaptive at Phase=0deg
reports:
  Freq. vs. pass: re(Mode(1)), re(Mode(2)), re(Mode(3)), re(Mode(4)), re(Mode(5)) vs Pass on Setup1 : AdaptivePass

design CavityCopperPins (HFSS, Eigenmode, model units mm)
variables:
  PinHolePos = 13mm  # optimise -88.5mm..-29.5mm
  PinHeight = 1.4mm
  chip_pos = 0.8mm
  PinHolePos2 = 8.9mm
  PinHeight2 = 2.4mm
  Lj = 5.35nH
  ReadoutPinLength = 6.3mm
  ReadoutPinHeight = 1.46mm
  DrivePinLength = 5.35mm
  DrivePinHeight = 2.69mm
geometry:
  SapphireHouse [copper] = cylinder(axis=Z, base_centre=(0mm, 0mm, $SapphireHouseStart), radius=$chip_surrounder_radius, height=$SapphireHouseEnd - ($SapphireHouseStart))
  ReadoutPin [copper] = cylinder(axis=X, base_centre=((-$chip_thickness/2) - ReadoutPinHeight, 0mm, $CavityEnd - PinHolePos), radius=$PinRadius, height=-ReadoutPinLength)
  Vacuum [vacuum] = cylinder(axis=Z, base_centre=(0mm, 0mm, $feedthrough_plate_z), radius=$chip_surrounder_radius_small, height=$SapphireHouseEnd - $feedthrough_plate_z)
  Cylinder2 = cylinder(axis=Z, base_centre=(0mm, 0mm, -16.5mm), radius=31m, height=$CavityEnd + 16.5 mm)
  PinHole2 = cylinder(axis=X, base_centre=(0, 0mm, $CavityEnd - PinHolePos), radius=$PinHoleRadius, height=-$chip_surrounder_radius)
  Cylinder3 = cylinder(axis=Z, base_centre=(0mm, 0mm, $CavityStart), radius=8mm, height=-27mm)
  Vacuum.unite(Cylinder2, Cylinder3, PinHole2)
  PinHole3 = cylinder(axis=X, base_centre=(0, 0mm, $CavityEnd - PinHolePos2), radius=$PinHoleRadius, height=$chip_surrounder_radius)
  Vacuum.unite(PinHole3)
  DrivePin [copper] = cylinder(axis=X, base_centre=((-$chip_thickness/2) + DrivePinHeight, 0mm, $CavityEnd - PinHolePos2), radius=$PinRadius, height=DrivePinLength)
  chip_holder1 = box(corner=(-$chip_thickness/2, -$chip_w/2, $coax_L), size=($chip_thickness, $chip_w, -$coax_L-$chip_penetration))
  chip_holder1.rotate(axis=Y, angle=180deg)
  chip_holder1.rotate(axis=Z, angle=180deg)
  chip_holder1.move(0mm, 0mm, $CavityEnd + chip_pos)
  feedthrough_outer_coax = cylinder(axis=Z, base_centre=(0mm, 0mm, $feedthrough_plate_z), radius=$feedthrough_coax_outer_radius, height=-$feedthrough_plate_z)
  feedthrough_pin [perfect conductor] = cylinder(axis=Z, base_centre=(0mm, 0mm, ($feedthrough_plate_z)), radius=$feedthrough_pin_radius, height=-$feedthrough_pin_length)
  Chamber7CavityB_2 [perfect conductor] = imported_body(C:\Users\barkayg\Dropbox (Weizmann Institute)\Quantum Circuits Lab\Barkay\SRF Cavity\Simulations\CavityQubit4Simulation.stp)
  SeamLine [non-model] = polyline((0, 2mm, $CavityEnd-6 mm) (-1.7453293e-06mm, -2mm, -46mm) (3.4906585e-06mm, 2mm, -46mm), AngularArc from point 0 over 3 centre=(0mm, 0mm, $CavityEnd-6 mm) angle=359.9999deg plane=XY)
  Chamber7Saphirdia4 [perfect conductor] = imported_body(C:\Users\barkayg\Dropbox (Weizmann Institute)\Quantum Circuits Lab\Barkay\SRF Cavity\Design\2020_12_15\Chamber 7 dia4.stp)
  Chamber7CavityB_2_1 = Chamber7CavityB_2.copy()
  Chamber7Saphirdia4_2 = Chamber7Saphirdia4.copy()
  Vacuum.subtract(Chamber7CavityB_2_1, Chamber7Saphirdia4_2)
  Vacuum.unite(feedthrough_outer_coax)
  feedthrough_pin1 = cylinder(axis=Z, base_centre=(0mm, 0mm, ($feedthrough_plate_z)), radius=2.184mm, height=-0.01mm)
  feedthrough_pin.unite(feedthrough_pin1)
  Chamber7Saphirdia4_3 = Chamber7Saphirdia4.copy()
  chip_holder1_1 = chip_holder1.copy()
  DrivePin_1 = DrivePin.copy()
  ReadoutPin_1 = ReadoutPin.copy()
  Vacuum_1 = Vacuum.copy()
  SapphireHouse.subtract(Chamber7Saphirdia4_3, chip_holder1_1, DrivePin_1, ReadoutPin_1, Vacuum_1)
  chip_holder1.delete()
  rect_jj1 = rectangle(corner=(-$chip_thickness/2, -$jj_w/2, $CavityEnd+$chip_penetration-$antenna_depth-$antenna_L-$lead_L-$pad_L), y_size=$jj_w, z_size=-$jj_L)
  line_jj1 = polyline((-$chip_thickness/2, 0mm, $CavityEnd+$chip_penetration-$antenna_depth-$antenna_L-$lead_L-$pad_L) (-$chip_thickness/2, 0mm, $CavityEnd+$chip_penetration-$antenna_depth-$antenna_L-$lead_L-$pad_L-$jj_L))
  chip_holder2 [silicon_lossy] = box(corner=(-$chip_thickness/2, -$chip_w/2, $CavityEnd+$chip_penetration), size=($chip_thickness, $chip_w, -$chip_L))
  Transmon1 = rectangle(corner=(-$chip_thickness/2, -$pad_w/2, $CavityEnd+$chip_penetration-$antenna_depth-$antenna_L), y_size=$pad_w, z_size=-$pad_L)
  Rectangle15 = rectangle(corner=(-$chip_thickness/2, -$antenna_w/2, $CavityEnd+$chip_penetration-$antenna_depth), y_size=$antenna_w, z_size=-$antenna_L)
  Circle2 = circle(normal=X, centre=(-$chip_thickness/2, 0mm, $CavityEnd+$chip_penetration-$antenna_depth), radius=$antenna_R)
  Rectangle16 = rectangle(corner=(-$chip_thickness/2, -$lead_w/2, $CavityEnd+$chip_penetration-$antenna_depth-$antenna_L-$pad_L), y_size=$lead_w, z_size=-$lead_L)
  Transmon1.unite(Rectangle15, Circle2, Rectangle16)
  Transmon2 = rectangle(corner=(-$chip_thickness/2, -$pad_w/2, $CavityEnd+$chip_penetration-$antenna_depth-$antenna_L-$lead_L-$pad_L-$jj_L-$lead_L), y_size=$pad_w, z_size=-$pad_L)
  Rectangle17 = rectangle(corner=(-$chip_thickness/2, -$lead_w/2, $CavityEnd+$chip_penetration-$antenna_depth-$antenna_L-$lead_L-$pad_L-$jj_L), y_size=$lead_w, z_size=-$lead_L)
  Transmon2.unite(Rectangle17)
  ROresonator = rectangle(corner=(-$chip_thickness/2, -$ro_w/2, $CavityEnd+$chip_penetration-$antenna_depth-$antenna_L-$lead_L-$pad_L-$jj_L-$lead_L-$pad_L-$ro_gap), y_size=$ro_w, z_size=-$ro_L)
  group feedthrough_Group = feedthrough_pin
  group CavityQubit4Simulation = Chamber7CavityB_2, Chamber7Saphirdia4
  group TransmonChip = rect_jj1, line_jj1, chip_holder2, Transmon1, Transmon2, ROresonator
boundaries and excitations:
  ReadoutPinImpedance: Lumped RLC Faces=Vacuum.face(2 of 3) CurrentLine{ReadoutPin.edge(1 of 2) at -0.25 along -> Vacuum.edge(1 of 2) at -0.25 along} RLC_Type=Parallel Resistance=50ohm
  DrivePinImpedance: Lumped RLC Faces=Vacuum.face(3 of 3) CurrentLine{DrivePin.edge(2 of 2) at 0.25 along -> Vacuum.edge(2 of 2) at 0.25 along} RLC_Type=Parallel Resistance=50ohm
  CavityPinImpedance: Lumped RLC Faces=Vacuum.face(3 of 3) CurrentLine{feedthrough_pin.vertex(2 of 2) -> Vacuum.vertex(2 of 2)} RLC_Type=Parallel Resistance=50ohm
  SCelements: Perfect E Objects=[ROresonator, Transmon1, Transmon2]
  Lj: Lumped RLC Objects=rect_jj1 CurrentLine{middle of rect_jj1.edge(z opposite corner) -> middle of rect_jj1.edge(z at corner)} RLC_Type=Parallel Inductance=Lj
mesh:
  ChipSCs: LengthBased Objects=[Transmon2, ROresonator, Transmon1] MaxLength=0.1mm
  jj: LengthBased Objects=rect_jj1 MaxLength=4um
setups:
  Setup1: HfssEigen MinimumFrequency=3GHz NumModes=5 MaxDeltaFreq=0.4 ConvergeOnRealFreq=true MaximumPasses=16 MinimumPasses=3 MinimumConvergedPasses=2 PercentRefinement=30 BasisOrder=-1
source amplitudes:
  #-10:1, #-10:2, #-10:4, #-10:5: 0 0deg
  #-10:3: 1 0deg
field calculator expressions:
  Surface_Current_Seam = Fundamental_Quantity(1) | ScalarZ | Fundamental_Quantity(1) | ScalarZ | Conj | * | Real | EnterLine(SeamLine) | LineValue | Integrate | <Hx,Hy,Hz> | <Hx,Hy,Hz> | Conj | Dot | Real | EnterVolume(Vacuum) | VolumeValue | Integrate | /
field plots:
  Mag_E1, Vector_E1: E Field in Vacuum on Setup1 : LastAdaptive at Phase=0deg
  Vector_E2: E Field on Setup1 : LastAdaptive at Phase=0deg
  Mesh1, Mesh2: MeshPlots in chip_holder2 on Setup1 : LastAdaptive at Phase=0deg
reports:
  Freq. vs. pass: re(Mode(1)), re(Mode(2)), re(Mode(3)), re(Mode(4)), re(Mode(5)) vs Pass on Setup1 : AdaptivePass
